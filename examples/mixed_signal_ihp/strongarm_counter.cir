* The IHP SG13G2 StrongARM comparator template drives a co-simulated counter
* Eight decisions at a 500 MHz clock, inp 1 mV above inm in five of them
* (cycles 0, 1, 3, 5 and 6). The counter, clocked on each falling clock
* edge while the comparator still holds its decision, counts the cycles in
* which outn fell, so it reads 5 (q = 0101) after the last one.
XM5 outn outp vdd vdd sg13_lv_pmos w=2u l=0.13u ng=1 m=1
XM3 outn outp xp 0 sg13_lv_nmos w=2u l=0.13u ng=1 m=1
XM6 outp outn vdd vdd sg13_lv_pmos w=2u l=0.13u ng=1 m=1
XM4 outp outn xn 0 sg13_lv_nmos w=2u l=0.13u ng=1 m=1
XM1 xp inp s 0 sg13_lv_nmos w=8u l=0.13u ng=1 m=1
XM2 xn inm s 0 sg13_lv_nmos w=8u l=0.13u ng=1 m=1
XM0 s clk 0 0 sg13_lv_nmos w=8u l=0.13u ng=1 m=1
XM7 outn clk vdd vdd sg13_lv_pmos w=1u l=0.13u ng=1 m=1
XM9 xp clk vdd vdd sg13_lv_pmos w=1u l=0.13u ng=1 m=1
XM8 outp clk vdd vdd sg13_lv_pmos w=1u l=0.13u ng=1 m=1
XM10 xn clk vdd vdd sg13_lv_pmos w=1u l=0.13u ng=1 m=1
CN outn 0 5f
CP outp 0 5f
VDD vdd 0 1.2
VCLK clk 0 PULSE(0 1.2 20p 20p 20p 980p 2n)
VP inp 0 PWL(0 0.7005 1.50n 0.7005 1.55n 0.7005 3.50n 0.7005 3.55n 0.6995 5.50n 0.6995 5.55n 0.7005 7.50n 0.7005 7.55n 0.6995 9.50n 0.6995 9.55n 0.7005 11.50n 0.7005 11.55n 0.7005 13.50n 0.7005 13.55n 0.6995)
VM inm 0 0.7
* Analog to digital: the clock and the decision, each inverted, so the
* counter counts on the falling clock edge whenever outn is low.
Ad [clk outn] [clkd outnd] tobit
.model tobit adc_bridge(in_low=0.4 in_high=0.8)
Ainv1 clkd clkn inv
Ainv2 outnd dec inv
.model inv d_inverter(rise_delay=10p fall_delay=10p)
Acnt [clkn dec] [q3 q2 q1 q0] null counter
Aq [q3 q2 q1 q0] [vq3 vq2 vq1 vq0] toana
.model toana dac_bridge(out_low=0 out_high=1.2)
.tran 1p 16.5n
.end
